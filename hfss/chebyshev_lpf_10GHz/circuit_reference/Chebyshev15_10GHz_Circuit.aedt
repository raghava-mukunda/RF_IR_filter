# Ansys Electronics Desktop project, version 2025.2

design Chebyshev15_LPF (Circuit)
options: SParamCircuitDef IntegrationMethod=FFT
components:
  L1 = IND_(L=9.7708053e-10)
  C2 = CAP_(C=4.7191526e-13)
  L3 = IND_(L=1.7488972e-09)
  C4 = CAP_(C=5.3165475e-13)
  L5 = IND_(L=1.8246038e-09)
  C6 = CAP_(C=5.4180787e-13)
  L7 = IND_(L=1.8412488e-09)
  C8 = CAP_(C=5.4385963e-13)
  L9 = IND_(L=1.8412488e-09)
  C10 = CAP_(C=5.4180787e-13)
  L11 = IND_(L=1.8246038e-09)
  C12 = CAP_(C=5.3165475e-13)
  L13 = IND_(L=1.7488972e-09)
  C14 = CAP_(C=4.7191526e-13)
  L15 = IND_(L=9.7708053e-10)
  port Port1 rz=50ohm iz=0ohm EnableNoise=false noisetemp=16.85cel
  port Port2 rz=50ohm iz=0ohm EnableNoise=false noisetemp=16.85cel
nets:
  0: C4.1, C2.1, C6.1, C8.1, C14.1, C10.1, C12.1
  net_1: L1.1, C2.0, L3.0
  net_2: C4.0, L3.1, L5.0
  net_3: L5.1, C6.0, L7.0
  net_4: C8.0, L7.1, L9.0
  net_5: L11.0, C10.0, L9.1
  net_6: L11.1, L13.0, C12.0
  net_7: C14.0, L15.0, L13.1
  Port1: L1.0
  Port2: L15.1
setups:
  FilterSweep: LinearFrequencyData(false, 0.1, false, "", false) SweepDefinition{Variable=Freq Data="LINC 0.1GHz 30GHz 2990"}
